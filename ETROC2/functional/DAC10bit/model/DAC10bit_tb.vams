// test the low pass filter
`include "disciplines.vams"
`timescale 1ns/1ps
module DAC10bit_tb (  );

reg a0, a1, a2, a3, a4, a5, a6, a7, a8, a9;
real IN;
reg pd;
initial begin
	a0 = 0;
	a1 = 0;
	a2 = 0;
	a3 = 0;
	a4 = 0;
	a5 = 0;
	a6 = 0;
	a7 = 0;
	a8 = 0;
	a9 = 0;
	IN = 0;
	pd = 0;
#1000
	IN = 1;
#1000
	a9 = 1;
#1000
	a8 = 1;
#200
	a7 = 1;
#1000
	$finish;
end
wreal out;

DAC10bit DAC10bit_inst(.a0(a0), .a1(a1), .a2(a2), .a3(a3), .a4(a4),
	.a5(a5), .a6(a6), .a7(a7), .a8(a8), .a9(a9), .out(out), .IN(IN), .pd(pd), .vdd(1.2), .vss(0.0));

endmodule
