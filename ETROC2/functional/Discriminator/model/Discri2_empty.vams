//////////////////////////////////////////////////////////////////////////////////
// Org:        	FNAL
// Author:      Quan Sun
//
// Create Date:    April. 19th, 2022
// Description: discriminator wreal model for ETROC
//
// Revision:
//
//
//////////////////////////////////////////////////////////////////////////////////

`timescale 1ps/1ps
//`include "constants.vams"
//`include "disciplines.vams"

module Discri2(inp, inn, HysSelB, pd, vss, vdd, ib, out);

input inp, inn, pd, vss, vdd, ib;
input [3:0] HysSelB;
output out;

endmodule
