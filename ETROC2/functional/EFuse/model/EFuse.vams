//Verilog-AMS HDL for "ETROC2_Core", "EFuse" "verilogams"

//`include "constants.vams"
//`include "disciplines.vams"

module EFuse ( EFuseQ, state, VDD, VDD2V5, VSS, TCKHP, en_clk, int_clk, mode, prog,
rst, start, EFuse_Bypass );

  input start;
  input  [31:0] prog;
  input  [1:0] mode;
  input rst;
  input int_clk;
  inout VDD2V5;
  inout VDD;
  output  [31:0] EFuseQ;
  input en_clk;
  inout VSS;
  output  [4:0] state;
  input  [3:0] TCKHP;
  input EFuse_Bypass;

assign EFuseQ = EFuse_Bypass?prog:0;
endmodule
