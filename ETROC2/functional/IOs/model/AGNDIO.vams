module AGNDIO(vss_IO, vss, vdd);
inout vss_IO, vss, vdd;
wreal vss_IO, vss, vdd;

endmodule
