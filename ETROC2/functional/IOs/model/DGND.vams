module DGND(vss_IO, vdd_IO, vss, vdd);
inout vss_IO, vdd_IO, vss, vdd;
wreal vss_IO, vdd_IO;

endmodule
