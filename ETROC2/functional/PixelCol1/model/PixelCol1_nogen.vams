//Verilog-AMS HDL for "ETROC2_Core", "PixelCol" "verilogams"

//`include "constants.vams"
//`include "disciplines.vams"

module PixelCol1 ( PAOut, busAddrOutA, busAddrOutB, busAddrOutC, busClkOutA,
busClkOutB, busClkOutC, busDataMisoOutA, busDataMisoOutB, busDataMisoOutC, busDataMosiOutA,
busDataMosiOutB, busDataMosiOutC, busReOutA, busReOutB, busReOutC, busRstOutA,
busRstOutB, busRstOutC, busTmrErrorOutA, busTmrErrorOutB, busTmrErrorOutC, busWeOutA,
busWeOutB, busWeOutC, columnAddrNextOutA, columnAddrNextOutB, columnAddrNextOutC,
dnData, dnHit, PAIn, VDD_D, VDD_Dis, VDD_PA, VDD_QInj, VSS_D, VSS_Dis, VSS_PA,
VSS_QInj, VSS_S, ClkRO, ClkTDC, QInj, RefStrobe, VRef, busAddrInA, busAddrInB,
busAddrInC, busClkInA, busClkInB, busClkInC, busDataMisoInA, busDataMisoInB,
busDataMisoInC, busDataMosiInA, busDataMosiInB, busDataMosiInC, busReInA, busReInB,
busReInC, busRstInA, busRstInB, busRstInC, busTmrErrorInA, busTmrErrorInB, busTmrErrorInC,
busWeInA, busWeInB, busWeInC, columnAddrInA, columnAddrInB, columnAddrInC, dnBCST,
dnRead );

input  [26:0] dnBCST;
input busRstInC;
inout VSS_PA;
input  [15:0] QInj;
input  [3:0] columnAddrInA;
input busRstInA;
inout VSS_QInj;
input busTmrErrorInB;
input VRef;
output  [4:0] dnHit;
inout VSS_D;
output busWeOutA;
input busClkInA;
output  [15:0] PAOut;
output busTmrErrorOutB;
output busReOutC;
input  [15:0] busAddrInA;
inout VDD_Dis;
output  [7:0] busDataMisoOutC;
output  [7:0] busDataMosiOutA;
inout VDD_QInj;
output busTmrErrorOutA;
output  [7:0] busDataMosiOutB;
input  [7:0] busDataMosiInA;
output  [3:0] columnAddrNextOutC;
output  [7:0] busDataMisoOutA;
output busTmrErrorOutC;
input busWeInA;
input busReInB;
inout VDD_D;
output busReOutA;
input dnRead;
output busClkOutB;
output busReOutB;
input busReInC;
input busClkInB;
output  [3:0] columnAddrNextOutA;
output  [7:0] busDataMosiOutC;
output busClkOutA;
input  [3:0] columnAddrInB;
input busRstInB;
input  [7:0] busDataMosiInC;
input  [15:0] busAddrInB;
input  [15:0] ClkRO;
input busWeInC;
input  [15:0] busAddrInC;
input  [15:0] RefStrobe;
inout VSS_S;
output busRstOutA;
output  [45:0] dnData;
output  [3:0] columnAddrNextOutB;
output busClkOutC;
input busWeInB;
input  [15:0] ClkTDC;
output  [7:0] busDataMisoOutB;
input busTmrErrorInC;
input  [7:0] busDataMisoInC;
input  [7:0] busDataMisoInB;
inout VDD_PA;
output busRstOutB;
output busWeOutB;
output busWeOutC;
output  [15:0] busAddrOutB;
output busRstOutC;
input  [3:0] columnAddrInC;
input busTmrErrorInA;
input busReInA;
input  [7:0] busDataMosiInB;
input  [7:0] busDataMisoInA;
inout  [15:0] PAIn;
output  [15:0] busAddrOutC;
input busClkInC;
output  [15:0] busAddrOutA;
inout VSS_Dis;

wreal VDD_Dis, VDD_PA, VDD_QInj, VSS_Dis, VSS_PA, VSS_QInj, VSS_S;
wire VDD_D, VSS_D;
wire [16:0] busTmrErrorA, busTmrErrorB, busTmrErrorC;
wire [16:0] busRstA, busRstB, busRstC;
wire [16:0] busWeA, busWeB, busWeC;
wire [16:0] colClkOutA, colClkOutB, colClkOutC;
wire [16:0] busReA, busReB, busReC;
wire [271:0] busAddrA, busAddrB, busAddrC;
wire [135:0] busDataMosiA, busDataMosiB, busDataMosiC;
wire [135:0] busDataMisoA, busDataMisoB, busDataMisoC;
wire [67:0] colAddrA, colAddrB, colAddrC;
wire [781:0] dataChain;
wire [84:0] hitChain;
wire [67:0] pixelAddrA, pixelAddrB, pixelAddrC;
wire [458:0] BCSTChain;
wire [16:0] readChain;
wire vlow, vlow_near;

assign dnData = dataChain[45:0];
assign dnHit = hitChain[4:0];
assign busDataMisoA[135:128] = {8{vlow}};
assign busDataMisoB[135:128] = {8{vlow}};
assign busDataMisoC[135:128] = {8{vlow}};
assign busTmrErrorA[16] = vlow;
assign busTmrErrorB[16] = vlow;
assign busTmrErrorC[16] = vlow;
assign BCSTChain[26:0] = dnBCST;
assign readChain[0] = dnRead;
assign pixelAddrA[3:0] = {4{vlow_near}};
assign pixelAddrB[3:0] = {4{vlow_near}};
assign pixelAddrC[3:0] = {4{vlow_near}};
assign dataChain[781:736] = {46{vlow}};
assign hitChain[84:80] = {5{vlow}};

// TIEL TIEL_inst(.VDD(VDD_D), .VSS(VSS_D), .ZN(vlow));
// TIEL TIEL_near_inst(.VDD(VDD_D), .VSS(VSS_D), .ZN(vlow_near));

TIEL_LVT_ELT TIEL_inst(.ZN(vlow), .VDD(VDD_D), .VSS(VSS_D));
TIEL_LVT_ELT TIEL_near_inst(.ZN(vlow_near), .VDD(VDD_D), .VSS(VSS_D));

Pixel1 Pixel1_inst_0(
      .PAOut(PAOut[0]),
      .busAddrOutA(busAddrA[(0+2)*16-1 : (0+1)*16]), .busAddrOutB(busAddrB[(0+2)*16-1 : (0+1)*16]), .busAddrOutC(busAddrC[(0+2)*16-1 : (0+1)*16]),
      .busClkOutA(colClkOutA[0+1]), .busClkOutB(colClkOutB[0+1]), .busClkOutC(colClkOutC[0+1]),
      .busDataMisoOutA(busDataMisoA[(0+1)*8-1 : 0*8]), .busDataMisoOutB(busDataMisoB[(0+1)*8-1 : 0*8]), .busDataMisoOutC(busDataMisoC[(0+1)*8-1 : 0*8]),
      .busDataMosiOutA(busDataMosiA[(0+2)*8-1 : (0+1)*8]), .busDataMosiOutB(busDataMosiB[(0+2)*8-1 : (0+1)*8]),
      .busDataMosiOutC(busDataMosiC[(0+2)*8-1 : (0+1)*8]),
      .busReOutA(busReA[0+1]), .busReOutB((busReB[0+1])), .busReOutC(busReC[0+1]),
      .busRstOutA(busRstA[0+1]), .busRstOutB(busRstB[0+1]), .busRstOutC(busRstC[0+1]),
      .busTmrErrorOutA(busTmrErrorA[0]), .busTmrErrorOutB(busTmrErrorB[0]), .busTmrErrorOutC(busTmrErrorC[0]),
      .busWeOutA(busWeA[0+1]), .busWeOutB(busWeB[0+1]), .busWeOutC(busWeC[0+1]),
      .colAddrOutA(colAddrA[(0+2)*4-1 : (0+1)*4]), .colAddrOutB(colAddrB[(0+2)*4-1 : (0+1)*4]), .colAddrOutC(colAddrC[(0+2)*4-1 : (0+1)*4]),
      .dnData(dataChain[(0+1)*46-1 : 0*46]), .dnHits(hitChain[(0+1)*5-1:0*5]),
      .pixelAddrNextOutA(pixelAddrA[(0+2)*4-1:(0+1)*4]), .pixelAddrNextOutB(pixelAddrB[(0+2)*4-1:(0+1)*4]), .pixelAddrNextOutC(pixelAddrC[(0+2)*4-1:(0+1)*4]),
      .upBCST(BCSTChain[(0+2)*27-1:(0+1)*27]), .upRead(readChain[0+1]), .PAIn(PAIn[0]),
      .VDD_D(VDD_D), .VDD_Dis(VDD_Dis), .VDD_PA(VDD_PA), .VDD_QInj(VDD_QInj),
      .VSS_D(VSS_D), .VSS_Dis(VSS_Dis), .VSS_PA(VSS_PA), .VSS_QInj(VSS_QInj), .VSS_S(VSS_S),
      .CLKRO(ClkRO[0]), .ClkTDC(ClkTDC[0]), .QInj(QInj[0]), .RefStrobe(RefStrobe[0]), .VRef(VRef),
      .busAddrInA(busAddrA[(0+1)*16-1:0*16]), .busAddrInB(busAddrB[(0+1)*16-1:0*16]), .busAddrInC(busAddrC[(0+1)*16-1:0*16]),
      .busClkInA(colClkOutA[0]), .busClkInB(colClkOutB[0]), .busClkInC(colClkOutC[0]),
      .busDataMisoInA(busDataMisoA[(0+2)*8-1 : (0+1)*8]), .busDataMisoInB(busDataMisoB[(0+2)*8-1 : (0+1)*8]), .busDataMisoInC(busDataMisoC[(0+2)*8-1 : (0+1)*8]),
      .busDataMosiInA(busDataMosiA[(0+1)*8-1 : 0*8]), .busDataMosiInB(busDataMosiB[(0+1)*8-1 : 0*8]), .busDataMosiInC(busDataMosiC[(0+1)*8-1 : 0*8]),
      .busReInA(busReA[0]), .busReInB(busReB[0]), .busReInC(busReC[0]),
      .busRstInA(busRstA[0]), .busRstInB(busRstB[0]), .busRstInC(busRstC[0]),
      .busTmrErrorInA(busTmrErrorA[0+1]), .busTmrErrorInB(busTmrErrorB[0+1]), .busTmrErrorInC(busTmrErrorC[0+1]),
      .busWeInA(busWeA[0]), .busWeInB(busWeB[0]), .busWeInC(busWeC[0]),
      .colAddrInA(colAddrA[(0+1)*4-1 : 0*4]), .colAddrInB(colAddrB[(0+1)*4-1 : 0*4]), .colAddrInC(colAddrC[(0+1)*4-1 : 0*4]),
      .dnBCST(BCSTChain[(0+1)*27-1:0*27]), .dnRead(readChain[0]),
      .pixelAddrInA(pixelAddrA[(0+1)*4-1 : 0*4]), .pixelAddrInB(pixelAddrB[(0+1)*4-1 : 0*4]), .pixelAddrInC(pixelAddrC[(0+1)*4-1 : 0*4]),
      .upData(dataChain[(0+2)*46-1 : (0+1)*46]), .upHits(hitChain[(0+2)*5-1 : (0+1)*5]) );

Pixel1 Pixel1_inst_1(
        .PAOut(PAOut[1]),
        .busAddrOutA(busAddrA[(1+2)*16-1 : (1+1)*16]), .busAddrOutB(busAddrB[(1+2)*16-1 : (1+1)*16]), .busAddrOutC(busAddrC[(1+2)*16-1 : (1+1)*16]),
        .busClkOutA(colClkOutA[1+1]), .busClkOutB(colClkOutB[1+1]), .busClkOutC(colClkOutC[1+1]),
        .busDataMisoOutA(busDataMisoA[(1+1)*8-1 : 1*8]), .busDataMisoOutB(busDataMisoB[(1+1)*8-1 : 1*8]), .busDataMisoOutC(busDataMisoC[(1+1)*8-1 : 1*8]),
        .busDataMosiOutA(busDataMosiA[(1+2)*8-1 : (1+1)*8]), .busDataMosiOutB(busDataMosiB[(1+2)*8-1 : (1+1)*8]),
        .busDataMosiOutC(busDataMosiC[(1+2)*8-1 : (1+1)*8]),
        .busReOutA(busReA[1+1]), .busReOutB((busReB[1+1])), .busReOutC(busReC[1+1]),
        .busRstOutA(busRstA[1+1]), .busRstOutB(busRstB[1+1]), .busRstOutC(busRstC[1+1]),
        .busTmrErrorOutA(busTmrErrorA[1]), .busTmrErrorOutB(busTmrErrorB[1]), .busTmrErrorOutC(busTmrErrorC[1]),
        .busWeOutA(busWeA[1+1]), .busWeOutB(busWeB[1+1]), .busWeOutC(busWeC[1+1]),
        .colAddrOutA(colAddrA[(1+2)*4-1 : (1+1)*4]), .colAddrOutB(colAddrB[(1+2)*4-1 : (1+1)*4]), .colAddrOutC(colAddrC[(1+2)*4-1 : (1+1)*4]),
        .dnData(dataChain[(1+1)*46-1 : 1*46]), .dnHits(hitChain[(1+1)*5-1:1*5]),
        .pixelAddrNextOutA(pixelAddrA[(1+2)*4-1:(1+1)*4]), .pixelAddrNextOutB(pixelAddrB[(1+2)*4-1:(1+1)*4]), .pixelAddrNextOutC(pixelAddrC[(1+2)*4-1:(1+1)*4]),
        .upBCST(BCSTChain[(1+2)*27-1:(1+1)*27]), .upRead(readChain[1+1]), .PAIn(PAIn[1]),
        .VDD_D(VDD_D), .VDD_Dis(VDD_Dis), .VDD_PA(VDD_PA), .VDD_QInj(VDD_QInj),
        .VSS_D(VSS_D), .VSS_Dis(VSS_Dis), .VSS_PA(VSS_PA), .VSS_QInj(VSS_QInj), .VSS_S(VSS_S),
        .CLKRO(ClkRO[1]), .ClkTDC(ClkTDC[1]), .QInj(QInj[1]), .RefStrobe(RefStrobe[1]), .VRef(VRef),
        .busAddrInA(busAddrA[(1+1)*16-1:1*16]), .busAddrInB(busAddrB[(1+1)*16-1:1*16]), .busAddrInC(busAddrC[(1+1)*16-1:1*16]),
        .busClkInA(colClkOutA[1]), .busClkInB(colClkOutB[1]), .busClkInC(colClkOutC[1]),
        .busDataMisoInA(busDataMisoA[(1+2)*8-1 : (1+1)*8]), .busDataMisoInB(busDataMisoB[(1+2)*8-1 : (1+1)*8]), .busDataMisoInC(busDataMisoC[(1+2)*8-1 : (1+1)*8]),
        .busDataMosiInA(busDataMosiA[(1+1)*8-1 : 1*8]), .busDataMosiInB(busDataMosiB[(1+1)*8-1 : 1*8]), .busDataMosiInC(busDataMosiC[(1+1)*8-1 : 1*8]),
        .busReInA(busReA[1]), .busReInB(busReB[1]), .busReInC(busReC[1]),
        .busRstInA(busRstA[1]), .busRstInB(busRstB[1]), .busRstInC(busRstC[1]),
        .busTmrErrorInA(busTmrErrorA[1+1]), .busTmrErrorInB(busTmrErrorB[1+1]), .busTmrErrorInC(busTmrErrorC[1+1]),
        .busWeInA(busWeA[1]), .busWeInB(busWeB[1]), .busWeInC(busWeC[1]),
        .colAddrInA(colAddrA[(1+1)*4-1 : 1*4]), .colAddrInB(colAddrB[(1+1)*4-1 : 1*4]), .colAddrInC(colAddrC[(1+1)*4-1 : 1*4]),
        .dnBCST(BCSTChain[(1+1)*27-1:1*27]), .dnRead(readChain[1]),
        .pixelAddrInA(pixelAddrA[(1+1)*4-1 : 1*4]), .pixelAddrInB(pixelAddrB[(1+1)*4-1 : 1*4]), .pixelAddrInC(pixelAddrC[(1+1)*4-1 : 1*4]),
        .upData(dataChain[(1+2)*46-1 : (1+1)*46]), .upHits(hitChain[(1+2)*5-1 : (1+1)*5]) );

Pixel1 Pixel1_inst_2(
          .PAOut(PAOut[2]),
          .busAddrOutA(busAddrA[(2+2)*16-1 : (2+1)*16]), .busAddrOutB(busAddrB[(2+2)*16-1 : (2+1)*16]), .busAddrOutC(busAddrC[(2+2)*16-1 : (2+1)*16]),
          .busClkOutA(colClkOutA[2+1]), .busClkOutB(colClkOutB[2+1]), .busClkOutC(colClkOutC[2+1]),
          .busDataMisoOutA(busDataMisoA[(2+1)*8-1 : 2*8]), .busDataMisoOutB(busDataMisoB[(2+1)*8-1 : 2*8]), .busDataMisoOutC(busDataMisoC[(2+1)*8-1 : 2*8]),
          .busDataMosiOutA(busDataMosiA[(2+2)*8-1 : (2+1)*8]), .busDataMosiOutB(busDataMosiB[(2+2)*8-1 : (2+1)*8]),
          .busDataMosiOutC(busDataMosiC[(2+2)*8-1 : (2+1)*8]),
          .busReOutA(busReA[2+1]), .busReOutB((busReB[2+1])), .busReOutC(busReC[2+1]),
          .busRstOutA(busRstA[2+1]), .busRstOutB(busRstB[2+1]), .busRstOutC(busRstC[2+1]),
          .busTmrErrorOutA(busTmrErrorA[2]), .busTmrErrorOutB(busTmrErrorB[2]), .busTmrErrorOutC(busTmrErrorC[2]),
          .busWeOutA(busWeA[2+1]), .busWeOutB(busWeB[2+1]), .busWeOutC(busWeC[2+1]),
          .colAddrOutA(colAddrA[(2+2)*4-1 : (2+1)*4]), .colAddrOutB(colAddrB[(2+2)*4-1 : (2+1)*4]), .colAddrOutC(colAddrC[(2+2)*4-1 : (2+1)*4]),
          .dnData(dataChain[(2+1)*46-1 : 2*46]), .dnHits(hitChain[(2+1)*5-1:2*5]),
          .pixelAddrNextOutA(pixelAddrA[(2+2)*4-1:(2+1)*4]), .pixelAddrNextOutB(pixelAddrB[(2+2)*4-1:(2+1)*4]), .pixelAddrNextOutC(pixelAddrC[(2+2)*4-1:(2+1)*4]),
          .upBCST(BCSTChain[(2+2)*27-1:(2+1)*27]), .upRead(readChain[2+1]), .PAIn(PAIn[2]),
          .VDD_D(VDD_D), .VDD_Dis(VDD_Dis), .VDD_PA(VDD_PA), .VDD_QInj(VDD_QInj),
          .VSS_D(VSS_D), .VSS_Dis(VSS_Dis), .VSS_PA(VSS_PA), .VSS_QInj(VSS_QInj), .VSS_S(VSS_S),
          .CLKRO(ClkRO[2]), .ClkTDC(ClkTDC[2]), .QInj(QInj[2]), .RefStrobe(RefStrobe[2]), .VRef(VRef),
          .busAddrInA(busAddrA[(2+1)*16-1:2*16]), .busAddrInB(busAddrB[(2+1)*16-1:2*16]), .busAddrInC(busAddrC[(2+1)*16-1:2*16]),
          .busClkInA(colClkOutA[2]), .busClkInB(colClkOutB[2]), .busClkInC(colClkOutC[2]),
          .busDataMisoInA(busDataMisoA[(2+2)*8-1 : (2+1)*8]), .busDataMisoInB(busDataMisoB[(2+2)*8-1 : (2+1)*8]), .busDataMisoInC(busDataMisoC[(2+2)*8-1 : (2+1)*8]),
          .busDataMosiInA(busDataMosiA[(2+1)*8-1 : 2*8]), .busDataMosiInB(busDataMosiB[(2+1)*8-1 : 2*8]), .busDataMosiInC(busDataMosiC[(2+1)*8-1 : 2*8]),
          .busReInA(busReA[2]), .busReInB(busReB[2]), .busReInC(busReC[2]),
          .busRstInA(busRstA[2]), .busRstInB(busRstB[2]), .busRstInC(busRstC[2]),
          .busTmrErrorInA(busTmrErrorA[2+1]), .busTmrErrorInB(busTmrErrorB[2+1]), .busTmrErrorInC(busTmrErrorC[2+1]),
          .busWeInA(busWeA[2]), .busWeInB(busWeB[2]), .busWeInC(busWeC[2]),
          .colAddrInA(colAddrA[(2+1)*4-1 : 2*4]), .colAddrInB(colAddrB[(2+1)*4-1 : 2*4]), .colAddrInC(colAddrC[(2+1)*4-1 : 2*4]),
          .dnBCST(BCSTChain[(2+1)*27-1:2*27]), .dnRead(readChain[2]),
          .pixelAddrInA(pixelAddrA[(2+1)*4-1 : 2*4]), .pixelAddrInB(pixelAddrB[(2+1)*4-1 : 2*4]), .pixelAddrInC(pixelAddrC[(2+1)*4-1 : 2*4]),
          .upData(dataChain[(2+2)*46-1 : (2+1)*46]), .upHits(hitChain[(2+2)*5-1 : (2+1)*5]) );

Pixel1 Pixel1_inst_3(
            .PAOut(PAOut[3]),
            .busAddrOutA(busAddrA[(3+2)*16-1 : (3+1)*16]), .busAddrOutB(busAddrB[(3+2)*16-1 : (3+1)*16]), .busAddrOutC(busAddrC[(3+2)*16-1 : (3+1)*16]),
            .busClkOutA(colClkOutA[3+1]), .busClkOutB(colClkOutB[3+1]), .busClkOutC(colClkOutC[3+1]),
            .busDataMisoOutA(busDataMisoA[(3+1)*8-1 : 3*8]), .busDataMisoOutB(busDataMisoB[(3+1)*8-1 : 3*8]), .busDataMisoOutC(busDataMisoC[(3+1)*8-1 : 3*8]),
            .busDataMosiOutA(busDataMosiA[(3+2)*8-1 : (3+1)*8]), .busDataMosiOutB(busDataMosiB[(3+2)*8-1 : (3+1)*8]),
            .busDataMosiOutC(busDataMosiC[(3+2)*8-1 : (3+1)*8]),
            .busReOutA(busReA[3+1]), .busReOutB((busReB[3+1])), .busReOutC(busReC[3+1]),
            .busRstOutA(busRstA[3+1]), .busRstOutB(busRstB[3+1]), .busRstOutC(busRstC[3+1]),
            .busTmrErrorOutA(busTmrErrorA[3]), .busTmrErrorOutB(busTmrErrorB[3]), .busTmrErrorOutC(busTmrErrorC[3]),
            .busWeOutA(busWeA[3+1]), .busWeOutB(busWeB[3+1]), .busWeOutC(busWeC[3+1]),
            .colAddrOutA(colAddrA[(3+2)*4-1 : (3+1)*4]), .colAddrOutB(colAddrB[(3+2)*4-1 : (3+1)*4]), .colAddrOutC(colAddrC[(3+2)*4-1 : (3+1)*4]),
            .dnData(dataChain[(3+1)*46-1 : 3*46]), .dnHits(hitChain[(3+1)*5-1:3*5]),
            .pixelAddrNextOutA(pixelAddrA[(3+2)*4-1:(3+1)*4]), .pixelAddrNextOutB(pixelAddrB[(3+2)*4-1:(3+1)*4]), .pixelAddrNextOutC(pixelAddrC[(3+2)*4-1:(3+1)*4]),
            .upBCST(BCSTChain[(3+2)*27-1:(3+1)*27]), .upRead(readChain[3+1]), .PAIn(PAIn[3]),
            .VDD_D(VDD_D), .VDD_Dis(VDD_Dis), .VDD_PA(VDD_PA), .VDD_QInj(VDD_QInj),
            .VSS_D(VSS_D), .VSS_Dis(VSS_Dis), .VSS_PA(VSS_PA), .VSS_QInj(VSS_QInj), .VSS_S(VSS_S),
            .CLKRO(ClkRO[3]), .ClkTDC(ClkTDC[3]), .QInj(QInj[3]), .RefStrobe(RefStrobe[3]), .VRef(VRef),
            .busAddrInA(busAddrA[(3+1)*16-1:3*16]), .busAddrInB(busAddrB[(3+1)*16-1:3*16]), .busAddrInC(busAddrC[(3+1)*16-1:3*16]),
            .busClkInA(colClkOutA[3]), .busClkInB(colClkOutB[3]), .busClkInC(colClkOutC[3]),
            .busDataMisoInA(busDataMisoA[(3+2)*8-1 : (3+1)*8]), .busDataMisoInB(busDataMisoB[(3+2)*8-1 : (3+1)*8]), .busDataMisoInC(busDataMisoC[(3+2)*8-1 : (3+1)*8]),
            .busDataMosiInA(busDataMosiA[(3+1)*8-1 : 3*8]), .busDataMosiInB(busDataMosiB[(3+1)*8-1 : 3*8]), .busDataMosiInC(busDataMosiC[(3+1)*8-1 : 3*8]),
            .busReInA(busReA[3]), .busReInB(busReB[3]), .busReInC(busReC[3]),
            .busRstInA(busRstA[3]), .busRstInB(busRstB[3]), .busRstInC(busRstC[3]),
            .busTmrErrorInA(busTmrErrorA[3+1]), .busTmrErrorInB(busTmrErrorB[3+1]), .busTmrErrorInC(busTmrErrorC[3+1]),
            .busWeInA(busWeA[3]), .busWeInB(busWeB[3]), .busWeInC(busWeC[3]),
            .colAddrInA(colAddrA[(3+1)*4-1 : 3*4]), .colAddrInB(colAddrB[(3+1)*4-1 : 3*4]), .colAddrInC(colAddrC[(3+1)*4-1 : 3*4]),
            .dnBCST(BCSTChain[(3+1)*27-1:3*27]), .dnRead(readChain[3]),
            .pixelAddrInA(pixelAddrA[(3+1)*4-1 : 3*4]), .pixelAddrInB(pixelAddrB[(3+1)*4-1 : 3*4]), .pixelAddrInC(pixelAddrC[(3+1)*4-1 : 3*4]),
            .upData(dataChain[(3+2)*46-1 : (3+1)*46]), .upHits(hitChain[(3+2)*5-1 : (3+1)*5]) );

Pixel1 Pixel1_inst_4(
            .PAOut(PAOut[4]),
            .busAddrOutA(busAddrA[(4+2)*16-1 : (4+1)*16]), .busAddrOutB(busAddrB[(4+2)*16-1 : (4+1)*16]), .busAddrOutC(busAddrC[(4+2)*16-1 : (4+1)*16]),
            .busClkOutA(colClkOutA[4+1]), .busClkOutB(colClkOutB[4+1]), .busClkOutC(colClkOutC[4+1]),
            .busDataMisoOutA(busDataMisoA[(4+1)*8-1 : 4*8]), .busDataMisoOutB(busDataMisoB[(4+1)*8-1 : 4*8]), .busDataMisoOutC(busDataMisoC[(4+1)*8-1 : 4*8]),
            .busDataMosiOutA(busDataMosiA[(4+2)*8-1 : (4+1)*8]), .busDataMosiOutB(busDataMosiB[(4+2)*8-1 : (4+1)*8]),
            .busDataMosiOutC(busDataMosiC[(4+2)*8-1 : (4+1)*8]),
            .busReOutA(busReA[4+1]), .busReOutB((busReB[4+1])), .busReOutC(busReC[4+1]),
            .busRstOutA(busRstA[4+1]), .busRstOutB(busRstB[4+1]), .busRstOutC(busRstC[4+1]),
            .busTmrErrorOutA(busTmrErrorA[4]), .busTmrErrorOutB(busTmrErrorB[4]), .busTmrErrorOutC(busTmrErrorC[4]),
            .busWeOutA(busWeA[4+1]), .busWeOutB(busWeB[4+1]), .busWeOutC(busWeC[4+1]),
            .colAddrOutA(colAddrA[(4+2)*4-1 : (4+1)*4]), .colAddrOutB(colAddrB[(4+2)*4-1 : (4+1)*4]), .colAddrOutC(colAddrC[(4+2)*4-1 : (4+1)*4]),
            .dnData(dataChain[(4+1)*46-1 : 4*46]), .dnHits(hitChain[(4+1)*5-1:4*5]),
            .pixelAddrNextOutA(pixelAddrA[(4+2)*4-1:(4+1)*4]), .pixelAddrNextOutB(pixelAddrB[(4+2)*4-1:(4+1)*4]), .pixelAddrNextOutC(pixelAddrC[(4+2)*4-1:(4+1)*4]),
            .upBCST(BCSTChain[(4+2)*27-1:(4+1)*27]), .upRead(readChain[4+1]), .PAIn(PAIn[4]),
            .VDD_D(VDD_D), .VDD_Dis(VDD_Dis), .VDD_PA(VDD_PA), .VDD_QInj(VDD_QInj),
            .VSS_D(VSS_D), .VSS_Dis(VSS_Dis), .VSS_PA(VSS_PA), .VSS_QInj(VSS_QInj), .VSS_S(VSS_S),
            .CLKRO(ClkRO[4]), .ClkTDC(ClkTDC[4]), .QInj(QInj[4]), .RefStrobe(RefStrobe[4]), .VRef(VRef),
            .busAddrInA(busAddrA[(4+1)*16-1:4*16]), .busAddrInB(busAddrB[(4+1)*16-1:4*16]), .busAddrInC(busAddrC[(4+1)*16-1:4*16]),
            .busClkInA(colClkOutA[4]), .busClkInB(colClkOutB[4]), .busClkInC(colClkOutC[4]),
            .busDataMisoInA(busDataMisoA[(4+2)*8-1 : (4+1)*8]), .busDataMisoInB(busDataMisoB[(4+2)*8-1 : (4+1)*8]), .busDataMisoInC(busDataMisoC[(4+2)*8-1 : (4+1)*8]),
            .busDataMosiInA(busDataMosiA[(4+1)*8-1 : 4*8]), .busDataMosiInB(busDataMosiB[(4+1)*8-1 : 4*8]), .busDataMosiInC(busDataMosiC[(4+1)*8-1 : 4*8]),
            .busReInA(busReA[4]), .busReInB(busReB[4]), .busReInC(busReC[4]),
            .busRstInA(busRstA[4]), .busRstInB(busRstB[4]), .busRstInC(busRstC[4]),
            .busTmrErrorInA(busTmrErrorA[4+1]), .busTmrErrorInB(busTmrErrorB[4+1]), .busTmrErrorInC(busTmrErrorC[4+1]),
            .busWeInA(busWeA[4]), .busWeInB(busWeB[4]), .busWeInC(busWeC[4]),
            .colAddrInA(colAddrA[(4+1)*4-1 : 4*4]), .colAddrInB(colAddrB[(4+1)*4-1 : 4*4]), .colAddrInC(colAddrC[(4+1)*4-1 : 4*4]),
            .dnBCST(BCSTChain[(4+1)*27-1:4*27]), .dnRead(readChain[4]),
            .pixelAddrInA(pixelAddrA[(4+1)*4-1 : 4*4]), .pixelAddrInB(pixelAddrB[(4+1)*4-1 : 4*4]), .pixelAddrInC(pixelAddrC[(4+1)*4-1 : 4*4]),
            .upData(dataChain[(4+2)*46-1 : (4+1)*46]), .upHits(hitChain[(4+2)*5-1 : (4+1)*5]) );

Pixel1 Pixel1_inst_5(
        .PAOut(PAOut[5]),
        .busAddrOutA(busAddrA[(5+2)*16-1 : (5+1)*16]), .busAddrOutB(busAddrB[(5+2)*16-1 : (5+1)*16]), .busAddrOutC(busAddrC[(5+2)*16-1 : (5+1)*16]),
        .busClkOutA(colClkOutA[5+1]), .busClkOutB(colClkOutB[5+1]), .busClkOutC(colClkOutC[5+1]),
        .busDataMisoOutA(busDataMisoA[(5+1)*8-1 : 5*8]), .busDataMisoOutB(busDataMisoB[(5+1)*8-1 : 5*8]), .busDataMisoOutC(busDataMisoC[(5+1)*8-1 : 5*8]),
        .busDataMosiOutA(busDataMosiA[(5+2)*8-1 : (5+1)*8]), .busDataMosiOutB(busDataMosiB[(5+2)*8-1 : (5+1)*8]),
        .busDataMosiOutC(busDataMosiC[(5+2)*8-1 : (5+1)*8]),
        .busReOutA(busReA[5+1]), .busReOutB((busReB[5+1])), .busReOutC(busReC[5+1]),
        .busRstOutA(busRstA[5+1]), .busRstOutB(busRstB[5+1]), .busRstOutC(busRstC[5+1]),
        .busTmrErrorOutA(busTmrErrorA[5]), .busTmrErrorOutB(busTmrErrorB[5]), .busTmrErrorOutC(busTmrErrorC[5]),
        .busWeOutA(busWeA[5+1]), .busWeOutB(busWeB[5+1]), .busWeOutC(busWeC[5+1]),
        .colAddrOutA(colAddrA[(5+2)*4-1 : (5+1)*4]), .colAddrOutB(colAddrB[(5+2)*4-1 : (5+1)*4]), .colAddrOutC(colAddrC[(5+2)*4-1 : (5+1)*4]),
        .dnData(dataChain[(5+1)*46-1 : 5*46]), .dnHits(hitChain[(5+1)*5-1:5*5]),
        .pixelAddrNextOutA(pixelAddrA[(5+2)*4-1:(5+1)*4]), .pixelAddrNextOutB(pixelAddrB[(5+2)*4-1:(5+1)*4]), .pixelAddrNextOutC(pixelAddrC[(5+2)*4-1:(5+1)*4]),
        .upBCST(BCSTChain[(5+2)*27-1:(5+1)*27]), .upRead(readChain[5+1]), .PAIn(PAIn[5]),
        .VDD_D(VDD_D), .VDD_Dis(VDD_Dis), .VDD_PA(VDD_PA), .VDD_QInj(VDD_QInj),
        .VSS_D(VSS_D), .VSS_Dis(VSS_Dis), .VSS_PA(VSS_PA), .VSS_QInj(VSS_QInj), .VSS_S(VSS_S),
        .CLKRO(ClkRO[5]), .ClkTDC(ClkTDC[5]), .QInj(QInj[5]), .RefStrobe(RefStrobe[5]), .VRef(VRef),
        .busAddrInA(busAddrA[(5+1)*16-1:5*16]), .busAddrInB(busAddrB[(5+1)*16-1:5*16]), .busAddrInC(busAddrC[(5+1)*16-1:5*16]),
        .busClkInA(colClkOutA[5]), .busClkInB(colClkOutB[5]), .busClkInC(colClkOutC[5]),
        .busDataMisoInA(busDataMisoA[(5+2)*8-1 : (5+1)*8]), .busDataMisoInB(busDataMisoB[(5+2)*8-1 : (5+1)*8]), .busDataMisoInC(busDataMisoC[(5+2)*8-1 : (5+1)*8]),
        .busDataMosiInA(busDataMosiA[(5+1)*8-1 : 5*8]), .busDataMosiInB(busDataMosiB[(5+1)*8-1 : 5*8]), .busDataMosiInC(busDataMosiC[(5+1)*8-1 : 5*8]),
        .busReInA(busReA[5]), .busReInB(busReB[5]), .busReInC(busReC[5]),
        .busRstInA(busRstA[5]), .busRstInB(busRstB[5]), .busRstInC(busRstC[5]),
        .busTmrErrorInA(busTmrErrorA[5+1]), .busTmrErrorInB(busTmrErrorB[5+1]), .busTmrErrorInC(busTmrErrorC[5+1]),
        .busWeInA(busWeA[5]), .busWeInB(busWeB[5]), .busWeInC(busWeC[5]),
        .colAddrInA(colAddrA[(5+1)*4-1 : 5*4]), .colAddrInB(colAddrB[(5+1)*4-1 : 5*4]), .colAddrInC(colAddrC[(5+1)*4-1 : 5*4]),
        .dnBCST(BCSTChain[(5+1)*27-1:5*27]), .dnRead(readChain[5]),
        .pixelAddrInA(pixelAddrA[(5+1)*4-1 : 5*4]), .pixelAddrInB(pixelAddrB[(5+1)*4-1 : 5*4]), .pixelAddrInC(pixelAddrC[(5+1)*4-1 : 5*4]),
        .upData(dataChain[(5+2)*46-1 : (5+1)*46]), .upHits(hitChain[(5+2)*5-1 : (5+1)*5]) );

Pixel1 Pixel1_inst_6	(
      .PAOut(PAOut[6]),
      .busAddrOutA(busAddrA[(6+2)*16-1 : (6+1)*16]), .busAddrOutB(busAddrB[(6+2)*16-1 : (6+1)*16]), .busAddrOutC(busAddrC[(6+2)*16-1 : (6+1)*16]),
      .busClkOutA(colClkOutA[6+1]), .busClkOutB(colClkOutB[6+1]), .busClkOutC(colClkOutC[6+1]),
      .busDataMisoOutA(busDataMisoA[(6+1)*8-1 : 6*8]), .busDataMisoOutB(busDataMisoB[(6+1)*8-1 : 6*8]), .busDataMisoOutC(busDataMisoC[(6+1)*8-1 : 6*8]),
      .busDataMosiOutA(busDataMosiA[(6+2)*8-1 : (6+1)*8]), .busDataMosiOutB(busDataMosiB[(6+2)*8-1 : (6+1)*8]),
      .busDataMosiOutC(busDataMosiC[(6+2)*8-1 : (6+1)*8]),
      .busReOutA(busReA[6+1]), .busReOutB((busReB[6+1])), .busReOutC(busReC[6+1]),
      .busRstOutA(busRstA[6+1]), .busRstOutB(busRstB[6+1]), .busRstOutC(busRstC[6+1]),
      .busTmrErrorOutA(busTmrErrorA[6]), .busTmrErrorOutB(busTmrErrorB[6]), .busTmrErrorOutC(busTmrErrorC[6]),
      .busWeOutA(busWeA[6+1]), .busWeOutB(busWeB[6+1]), .busWeOutC(busWeC[6+1]),
      .colAddrOutA(colAddrA[(6+2)*4-1 : (6+1)*4]), .colAddrOutB(colAddrB[(6+2)*4-1 : (6+1)*4]), .colAddrOutC(colAddrC[(6+2)*4-1 : (6+1)*4]),
      .dnData(dataChain[(6+1)*46-1 : 6*46]), .dnHits(hitChain[(6+1)*5-1:6*5]),
      .pixelAddrNextOutA(pixelAddrA[(6+2)*4-1:(6+1)*4]), .pixelAddrNextOutB(pixelAddrB[(6+2)*4-1:(6+1)*4]), .pixelAddrNextOutC(pixelAddrC[(6+2)*4-1:(6+1)*4]),
      .upBCST(BCSTChain[(6+2)*27-1:(6+1)*27]), .upRead(readChain[6+1]), .PAIn(PAIn[6]),
      .VDD_D(VDD_D), .VDD_Dis(VDD_Dis), .VDD_PA(VDD_PA), .VDD_QInj(VDD_QInj),
      .VSS_D(VSS_D), .VSS_Dis(VSS_Dis), .VSS_PA(VSS_PA), .VSS_QInj(VSS_QInj), .VSS_S(VSS_S),
      .CLKRO(ClkRO[6]), .ClkTDC(ClkTDC[6]), .QInj(QInj[6]), .RefStrobe(RefStrobe[6]), .VRef(VRef),
      .busAddrInA(busAddrA[(6+1)*16-1:6*16]), .busAddrInB(busAddrB[(6+1)*16-1:6*16]), .busAddrInC(busAddrC[(6+1)*16-1:6*16]),
      .busClkInA(colClkOutA[6]), .busClkInB(colClkOutB[6]), .busClkInC(colClkOutC[6]),
      .busDataMisoInA(busDataMisoA[(6+2)*8-1 : (6+1)*8]), .busDataMisoInB(busDataMisoB[(6+2)*8-1 : (6+1)*8]), .busDataMisoInC(busDataMisoC[(6+2)*8-1 : (6+1)*8]),
      .busDataMosiInA(busDataMosiA[(6+1)*8-1 : 6*8]), .busDataMosiInB(busDataMosiB[(6+1)*8-1 : 6*8]), .busDataMosiInC(busDataMosiC[(6+1)*8-1 : 6*8]),
      .busReInA(busReA[6]), .busReInB(busReB[6]), .busReInC(busReC[6]),
      .busRstInA(busRstA[6]), .busRstInB(busRstB[6]), .busRstInC(busRstC[6]),
      .busTmrErrorInA(busTmrErrorA[6+1]), .busTmrErrorInB(busTmrErrorB[6+1]), .busTmrErrorInC(busTmrErrorC[6+1]),
      .busWeInA(busWeA[6]), .busWeInB(busWeB[6]), .busWeInC(busWeC[6]),
      .colAddrInA(colAddrA[(6+1)*4-1 : 6*4]), .colAddrInB(colAddrB[(6+1)*4-1 : 6*4]), .colAddrInC(colAddrC[(6+1)*4-1 : 6*4]),
      .dnBCST(BCSTChain[(6+1)*27-1:6*27]), .dnRead(readChain[6]),
      .pixelAddrInA(pixelAddrA[(6+1)*4-1 : 6*4]), .pixelAddrInB(pixelAddrB[(6+1)*4-1 : 6*4]), .pixelAddrInC(pixelAddrC[(6+1)*4-1 : 6*4]),
      .upData(dataChain[(6+2)*46-1 : (6+1)*46]), .upHits(hitChain[(6+2)*5-1 : (6+1)*5]) );

Pixel1 Pixel1_inst_7(
      .PAOut(PAOut[7]),
      .busAddrOutA(busAddrA[(7+2)*16-1 : (7+1)*16]), .busAddrOutB(busAddrB[(7+2)*16-1 : (7+1)*16]), .busAddrOutC(busAddrC[(7+2)*16-1 : (7+1)*16]),
      .busClkOutA(colClkOutA[7+1]), .busClkOutB(colClkOutB[7+1]), .busClkOutC(colClkOutC[7+1]),
      .busDataMisoOutA(busDataMisoA[(7+1)*8-1 : 7*8]), .busDataMisoOutB(busDataMisoB[(7+1)*8-1 : 7*8]), .busDataMisoOutC(busDataMisoC[(7+1)*8-1 : 7*8]),
      .busDataMosiOutA(busDataMosiA[(7+2)*8-1 : (7+1)*8]), .busDataMosiOutB(busDataMosiB[(7+2)*8-1 : (7+1)*8]),
      .busDataMosiOutC(busDataMosiC[(7+2)*8-1 : (7+1)*8]),
      .busReOutA(busReA[7+1]), .busReOutB((busReB[7+1])), .busReOutC(busReC[7+1]),
      .busRstOutA(busRstA[7+1]), .busRstOutB(busRstB[7+1]), .busRstOutC(busRstC[7+1]),
      .busTmrErrorOutA(busTmrErrorA[7]), .busTmrErrorOutB(busTmrErrorB[7]), .busTmrErrorOutC(busTmrErrorC[7]),
      .busWeOutA(busWeA[7+1]), .busWeOutB(busWeB[7+1]), .busWeOutC(busWeC[7+1]),
      .colAddrOutA(colAddrA[(7+2)*4-1 : (7+1)*4]), .colAddrOutB(colAddrB[(7+2)*4-1 : (7+1)*4]), .colAddrOutC(colAddrC[(7+2)*4-1 : (7+1)*4]),
      .dnData(dataChain[(7+1)*46-1 : 7*46]), .dnHits(hitChain[(7+1)*5-1:7*5]),
      .pixelAddrNextOutA(pixelAddrA[(7+2)*4-1:(7+1)*4]), .pixelAddrNextOutB(pixelAddrB[(7+2)*4-1:(7+1)*4]), .pixelAddrNextOutC(pixelAddrC[(7+2)*4-1:(7+1)*4]),
      .upBCST(BCSTChain[(7+2)*27-1:(7+1)*27]), .upRead(readChain[7+1]), .PAIn(PAIn[7]),
      .VDD_D(VDD_D), .VDD_Dis(VDD_Dis), .VDD_PA(VDD_PA), .VDD_QInj(VDD_QInj),
      .VSS_D(VSS_D), .VSS_Dis(VSS_Dis), .VSS_PA(VSS_PA), .VSS_QInj(VSS_QInj), .VSS_S(VSS_S),
      .CLKRO(ClkRO[7]), .ClkTDC(ClkTDC[7]), .QInj(QInj[7]), .RefStrobe(RefStrobe[7]), .VRef(VRef),
      .busAddrInA(busAddrA[(7+1)*16-1:7*16]), .busAddrInB(busAddrB[(7+1)*16-1:7*16]), .busAddrInC(busAddrC[(7+1)*16-1:7*16]),
      .busClkInA(colClkOutA[7]), .busClkInB(colClkOutB[7]), .busClkInC(colClkOutC[7]),
      .busDataMisoInA(busDataMisoA[(7+2)*8-1 : (7+1)*8]), .busDataMisoInB(busDataMisoB[(7+2)*8-1 : (7+1)*8]), .busDataMisoInC(busDataMisoC[(7+2)*8-1 : (7+1)*8]),
      .busDataMosiInA(busDataMosiA[(7+1)*8-1 : 7*8]), .busDataMosiInB(busDataMosiB[(7+1)*8-1 : 7*8]), .busDataMosiInC(busDataMosiC[(7+1)*8-1 : 7*8]),
      .busReInA(busReA[7]), .busReInB(busReB[7]), .busReInC(busReC[7]),
      .busRstInA(busRstA[7]), .busRstInB(busRstB[7]), .busRstInC(busRstC[7]),
      .busTmrErrorInA(busTmrErrorA[7+1]), .busTmrErrorInB(busTmrErrorB[7+1]), .busTmrErrorInC(busTmrErrorC[7+1]),
      .busWeInA(busWeA[7]), .busWeInB(busWeB[7]), .busWeInC(busWeC[7]),
      .colAddrInA(colAddrA[(7+1)*4-1 : 7*4]), .colAddrInB(colAddrB[(7+1)*4-1 : 7*4]), .colAddrInC(colAddrC[(7+1)*4-1 : 7*4]),
      .dnBCST(BCSTChain[(7+1)*27-1:7*27]), .dnRead(readChain[7]),
      .pixelAddrInA(pixelAddrA[(7+1)*4-1 : 7*4]), .pixelAddrInB(pixelAddrB[(7+1)*4-1 : 7*4]), .pixelAddrInC(pixelAddrC[(7+1)*4-1 : 7*4]),
      .upData(dataChain[(7+2)*46-1 : (7+1)*46]), .upHits(hitChain[(7+2)*5-1 : (7+1)*5]) );

Pixel1 Pixel1_inst_8(
      .PAOut(PAOut[8]),
      .busAddrOutA(busAddrA[(8+2)*16-1 : (8+1)*16]), .busAddrOutB(busAddrB[(8+2)*16-1 : (8+1)*16]), .busAddrOutC(busAddrC[(8+2)*16-1 : (8+1)*16]),
      .busClkOutA(colClkOutA[8+1]), .busClkOutB(colClkOutB[8+1]), .busClkOutC(colClkOutC[8+1]),
      .busDataMisoOutA(busDataMisoA[(8+1)*8-1 : 8*8]), .busDataMisoOutB(busDataMisoB[(8+1)*8-1 : 8*8]), .busDataMisoOutC(busDataMisoC[(8+1)*8-1 : 8*8]),
      .busDataMosiOutA(busDataMosiA[(8+2)*8-1 : (8+1)*8]), .busDataMosiOutB(busDataMosiB[(8+2)*8-1 : (8+1)*8]),
      .busDataMosiOutC(busDataMosiC[(8+2)*8-1 : (8+1)*8]),
      .busReOutA(busReA[8+1]), .busReOutB((busReB[8+1])), .busReOutC(busReC[8+1]),
      .busRstOutA(busRstA[8+1]), .busRstOutB(busRstB[8+1]), .busRstOutC(busRstC[8+1]),
      .busTmrErrorOutA(busTmrErrorA[8]), .busTmrErrorOutB(busTmrErrorB[8]), .busTmrErrorOutC(busTmrErrorC[8]),
      .busWeOutA(busWeA[8+1]), .busWeOutB(busWeB[8+1]), .busWeOutC(busWeC[8+1]),
      .colAddrOutA(colAddrA[(8+2)*4-1 : (8+1)*4]), .colAddrOutB(colAddrB[(8+2)*4-1 : (8+1)*4]), .colAddrOutC(colAddrC[(8+2)*4-1 : (8+1)*4]),
      .dnData(dataChain[(8+1)*46-1 : 8*46]), .dnHits(hitChain[(8+1)*5-1:8*5]),
      .pixelAddrNextOutA(pixelAddrA[(8+2)*4-1:(8+1)*4]), .pixelAddrNextOutB(pixelAddrB[(8+2)*4-1:(8+1)*4]), .pixelAddrNextOutC(pixelAddrC[(8+2)*4-1:(8+1)*4]),
      .upBCST(BCSTChain[(8+2)*27-1:(8+1)*27]), .upRead(readChain[8+1]), .PAIn(PAIn[8]),
      .VDD_D(VDD_D), .VDD_Dis(VDD_Dis), .VDD_PA(VDD_PA), .VDD_QInj(VDD_QInj),
      .VSS_D(VSS_D), .VSS_Dis(VSS_Dis), .VSS_PA(VSS_PA), .VSS_QInj(VSS_QInj), .VSS_S(VSS_S),
      .CLKRO(ClkRO[8]), .ClkTDC(ClkTDC[8]), .QInj(QInj[8]), .RefStrobe(RefStrobe[8]), .VRef(VRef),
      .busAddrInA(busAddrA[(8+1)*16-1:8*16]), .busAddrInB(busAddrB[(8+1)*16-1:8*16]), .busAddrInC(busAddrC[(8+1)*16-1:8*16]),
      .busClkInA(colClkOutA[8]), .busClkInB(colClkOutB[8]), .busClkInC(colClkOutC[8]),
      .busDataMisoInA(busDataMisoA[(8+2)*8-1 : (8+1)*8]), .busDataMisoInB(busDataMisoB[(8+2)*8-1 : (8+1)*8]), .busDataMisoInC(busDataMisoC[(8+2)*8-1 : (8+1)*8]),
      .busDataMosiInA(busDataMosiA[(8+1)*8-1 : 8*8]), .busDataMosiInB(busDataMosiB[(8+1)*8-1 : 8*8]), .busDataMosiInC(busDataMosiC[(8+1)*8-1 : 8*8]),
      .busReInA(busReA[8]), .busReInB(busReB[8]), .busReInC(busReC[8]),
      .busRstInA(busRstA[8]), .busRstInB(busRstB[8]), .busRstInC(busRstC[8]),
      .busTmrErrorInA(busTmrErrorA[8+1]), .busTmrErrorInB(busTmrErrorB[8+1]), .busTmrErrorInC(busTmrErrorC[8+1]),
      .busWeInA(busWeA[8]), .busWeInB(busWeB[8]), .busWeInC(busWeC[8]),
      .colAddrInA(colAddrA[(8+1)*4-1 : 8*4]), .colAddrInB(colAddrB[(8+1)*4-1 : 8*4]), .colAddrInC(colAddrC[(8+1)*4-1 : 8*4]),
      .dnBCST(BCSTChain[(8+1)*27-1:8*27]), .dnRead(readChain[8]),
      .pixelAddrInA(pixelAddrA[(8+1)*4-1 : 8*4]), .pixelAddrInB(pixelAddrB[(8+1)*4-1 : 8*4]), .pixelAddrInC(pixelAddrC[(8+1)*4-1 : 8*4]),
      .upData(dataChain[(8+2)*46-1 : (8+1)*46]), .upHits(hitChain[(8+2)*5-1 : (8+1)*5]) );

Pixel1 Pixel1_inst_9(
      .PAOut(PAOut[9]),
      .busAddrOutA(busAddrA[(9+2)*16-1 : (9+1)*16]), .busAddrOutB(busAddrB[(9+2)*16-1 : (9+1)*16]), .busAddrOutC(busAddrC[(9+2)*16-1 : (9+1)*16]),
      .busClkOutA(colClkOutA[9+1]), .busClkOutB(colClkOutB[9+1]), .busClkOutC(colClkOutC[9+1]),
      .busDataMisoOutA(busDataMisoA[(9+1)*8-1 : 9*8]), .busDataMisoOutB(busDataMisoB[(9+1)*8-1 : 9*8]), .busDataMisoOutC(busDataMisoC[(9+1)*8-1 : 9*8]),
      .busDataMosiOutA(busDataMosiA[(9+2)*8-1 : (9+1)*8]), .busDataMosiOutB(busDataMosiB[(9+2)*8-1 : (9+1)*8]),
      .busDataMosiOutC(busDataMosiC[(9+2)*8-1 : (9+1)*8]),
      .busReOutA(busReA[9+1]), .busReOutB((busReB[9+1])), .busReOutC(busReC[9+1]),
      .busRstOutA(busRstA[9+1]), .busRstOutB(busRstB[9+1]), .busRstOutC(busRstC[9+1]),
      .busTmrErrorOutA(busTmrErrorA[9]), .busTmrErrorOutB(busTmrErrorB[9]), .busTmrErrorOutC(busTmrErrorC[9]),
      .busWeOutA(busWeA[9+1]), .busWeOutB(busWeB[9+1]), .busWeOutC(busWeC[9+1]),
      .colAddrOutA(colAddrA[(9+2)*4-1 : (9+1)*4]), .colAddrOutB(colAddrB[(9+2)*4-1 : (9+1)*4]), .colAddrOutC(colAddrC[(9+2)*4-1 : (9+1)*4]),
      .dnData(dataChain[(9+1)*46-1 : 9*46]), .dnHits(hitChain[(9+1)*5-1:9*5]),
      .pixelAddrNextOutA(pixelAddrA[(9+2)*4-1:(9+1)*4]), .pixelAddrNextOutB(pixelAddrB[(9+2)*4-1:(9+1)*4]), .pixelAddrNextOutC(pixelAddrC[(9+2)*4-1:(9+1)*4]),
      .upBCST(BCSTChain[(9+2)*27-1:(9+1)*27]), .upRead(readChain[9+1]), .PAIn(PAIn[9]),
      .VDD_D(VDD_D), .VDD_Dis(VDD_Dis), .VDD_PA(VDD_PA), .VDD_QInj(VDD_QInj),
      .VSS_D(VSS_D), .VSS_Dis(VSS_Dis), .VSS_PA(VSS_PA), .VSS_QInj(VSS_QInj), .VSS_S(VSS_S),
      .CLKRO(ClkRO[9]), .ClkTDC(ClkTDC[9]), .QInj(QInj[9]), .RefStrobe(RefStrobe[9]), .VRef(VRef),
      .busAddrInA(busAddrA[(9+1)*16-1:9*16]), .busAddrInB(busAddrB[(9+1)*16-1:9*16]), .busAddrInC(busAddrC[(9+1)*16-1:9*16]),
      .busClkInA(colClkOutA[9]), .busClkInB(colClkOutB[9]), .busClkInC(colClkOutC[9]),
      .busDataMisoInA(busDataMisoA[(9+2)*8-1 : (9+1)*8]), .busDataMisoInB(busDataMisoB[(9+2)*8-1 : (9+1)*8]), .busDataMisoInC(busDataMisoC[(9+2)*8-1 : (9+1)*8]),
      .busDataMosiInA(busDataMosiA[(9+1)*8-1 : 9*8]), .busDataMosiInB(busDataMosiB[(9+1)*8-1 : 9*8]), .busDataMosiInC(busDataMosiC[(9+1)*8-1 : 9*8]),
      .busReInA(busReA[9]), .busReInB(busReB[9]), .busReInC(busReC[9]),
      .busRstInA(busRstA[9]), .busRstInB(busRstB[9]), .busRstInC(busRstC[9]),
      .busTmrErrorInA(busTmrErrorA[9+1]), .busTmrErrorInB(busTmrErrorB[9+1]), .busTmrErrorInC(busTmrErrorC[9+1]),
      .busWeInA(busWeA[9]), .busWeInB(busWeB[9]), .busWeInC(busWeC[9]),
      .colAddrInA(colAddrA[(9+1)*4-1 : 9*4]), .colAddrInB(colAddrB[(9+1)*4-1 : 9*4]), .colAddrInC(colAddrC[(9+1)*4-1 : 9*4]),
      .dnBCST(BCSTChain[(9+1)*27-1:9*27]), .dnRead(readChain[9]),
      .pixelAddrInA(pixelAddrA[(9+1)*4-1 : 9*4]), .pixelAddrInB(pixelAddrB[(9+1)*4-1 : 9*4]), .pixelAddrInC(pixelAddrC[(9+1)*4-1 : 9*4]),
      .upData(dataChain[(9+2)*46-1 : (9+1)*46]), .upHits(hitChain[(9+2)*5-1 : (9+1)*5]) );

Pixel1 Pixel1_inst_10(
        .PAOut(PAOut[10]),
        .busAddrOutA(busAddrA[(10+2)*16-1 : (10+1)*16]), .busAddrOutB(busAddrB[(10+2)*16-1 : (10+1)*16]), .busAddrOutC(busAddrC[(10+2)*16-1 : (10+1)*16]),
        .busClkOutA(colClkOutA[10+1]), .busClkOutB(colClkOutB[10+1]), .busClkOutC(colClkOutC[10+1]),
        .busDataMisoOutA(busDataMisoA[(10+1)*8-1 : 10*8]), .busDataMisoOutB(busDataMisoB[(10+1)*8-1 : 10*8]), .busDataMisoOutC(busDataMisoC[(10+1)*8-1 : 10*8]),
        .busDataMosiOutA(busDataMosiA[(10+2)*8-1 : (10+1)*8]), .busDataMosiOutB(busDataMosiB[(10+2)*8-1 : (10+1)*8]),
        .busDataMosiOutC(busDataMosiC[(10+2)*8-1 : (10+1)*8]),
        .busReOutA(busReA[10+1]), .busReOutB((busReB[10+1])), .busReOutC(busReC[10+1]),
        .busRstOutA(busRstA[10+1]), .busRstOutB(busRstB[10+1]), .busRstOutC(busRstC[10+1]),
        .busTmrErrorOutA(busTmrErrorA[10]), .busTmrErrorOutB(busTmrErrorB[10]), .busTmrErrorOutC(busTmrErrorC[10]),
        .busWeOutA(busWeA[10+1]), .busWeOutB(busWeB[10+1]), .busWeOutC(busWeC[10+1]),
        .colAddrOutA(colAddrA[(10+2)*4-1 : (10+1)*4]), .colAddrOutB(colAddrB[(10+2)*4-1 : (10+1)*4]), .colAddrOutC(colAddrC[(10+2)*4-1 : (10+1)*4]),
        .dnData(dataChain[(10+1)*46-1 : 10*46]), .dnHits(hitChain[(10+1)*5-1:10*5]),
        .pixelAddrNextOutA(pixelAddrA[(10+2)*4-1:(10+1)*4]), .pixelAddrNextOutB(pixelAddrB[(10+2)*4-1:(10+1)*4]), .pixelAddrNextOutC(pixelAddrC[(10+2)*4-1:(10+1)*4]),
        .upBCST(BCSTChain[(10+2)*27-1:(10+1)*27]), .upRead(readChain[10+1]), .PAIn(PAIn[10]),
        .VDD_D(VDD_D), .VDD_Dis(VDD_Dis), .VDD_PA(VDD_PA), .VDD_QInj(VDD_QInj),
        .VSS_D(VSS_D), .VSS_Dis(VSS_Dis), .VSS_PA(VSS_PA), .VSS_QInj(VSS_QInj), .VSS_S(VSS_S),
        .CLKRO(ClkRO[10]), .ClkTDC(ClkTDC[10]), .QInj(QInj[10]), .RefStrobe(RefStrobe[10]), .VRef(VRef),
        .busAddrInA(busAddrA[(10+1)*16-1:10*16]), .busAddrInB(busAddrB[(10+1)*16-1:10*16]), .busAddrInC(busAddrC[(10+1)*16-1:10*16]),
        .busClkInA(colClkOutA[10]), .busClkInB(colClkOutB[10]), .busClkInC(colClkOutC[10]),
        .busDataMisoInA(busDataMisoA[(10+2)*8-1 : (10+1)*8]), .busDataMisoInB(busDataMisoB[(10+2)*8-1 : (10+1)*8]), .busDataMisoInC(busDataMisoC[(10+2)*8-1 : (10+1)*8]),
        .busDataMosiInA(busDataMosiA[(10+1)*8-1 : 10*8]), .busDataMosiInB(busDataMosiB[(10+1)*8-1 : 10*8]), .busDataMosiInC(busDataMosiC[(10+1)*8-1 : 10*8]),
        .busReInA(busReA[10]), .busReInB(busReB[10]), .busReInC(busReC[10]),
        .busRstInA(busRstA[10]), .busRstInB(busRstB[10]), .busRstInC(busRstC[10]),
        .busTmrErrorInA(busTmrErrorA[10+1]), .busTmrErrorInB(busTmrErrorB[10+1]), .busTmrErrorInC(busTmrErrorC[10+1]),
        .busWeInA(busWeA[10]), .busWeInB(busWeB[10]), .busWeInC(busWeC[10]),
        .colAddrInA(colAddrA[(10+1)*4-1 : 10*4]), .colAddrInB(colAddrB[(10+1)*4-1 : 10*4]), .colAddrInC(colAddrC[(10+1)*4-1 : 10*4]),
        .dnBCST(BCSTChain[(10+1)*27-1:10*27]), .dnRead(readChain[10]),
        .pixelAddrInA(pixelAddrA[(10+1)*4-1 : 10*4]), .pixelAddrInB(pixelAddrB[(10+1)*4-1 : 10*4]), .pixelAddrInC(pixelAddrC[(10+1)*4-1 : 10*4]),
        .upData(dataChain[(10+2)*46-1 : (10+1)*46]), .upHits(hitChain[(10+2)*5-1 : (10+1)*5]) );

Pixel1 Pixel1_inst_11(
      .PAOut(PAOut[11]),
      .busAddrOutA(busAddrA[(11+2)*16-1 : (11+1)*16]), .busAddrOutB(busAddrB[(11+2)*16-1 : (11+1)*16]), .busAddrOutC(busAddrC[(11+2)*16-1 : (11+1)*16]),
      .busClkOutA(colClkOutA[11+1]), .busClkOutB(colClkOutB[11+1]), .busClkOutC(colClkOutC[11+1]),
      .busDataMisoOutA(busDataMisoA[(11+1)*8-1 : 11*8]), .busDataMisoOutB(busDataMisoB[(11+1)*8-1 : 11*8]), .busDataMisoOutC(busDataMisoC[(11+1)*8-1 : 11*8]),
      .busDataMosiOutA(busDataMosiA[(11+2)*8-1 : (11+1)*8]), .busDataMosiOutB(busDataMosiB[(11+2)*8-1 : (11+1)*8]),
      .busDataMosiOutC(busDataMosiC[(11+2)*8-1 : (11+1)*8]),
      .busReOutA(busReA[11+1]), .busReOutB((busReB[11+1])), .busReOutC(busReC[11+1]),
      .busRstOutA(busRstA[11+1]), .busRstOutB(busRstB[11+1]), .busRstOutC(busRstC[11+1]),
      .busTmrErrorOutA(busTmrErrorA[11]), .busTmrErrorOutB(busTmrErrorB[11]), .busTmrErrorOutC(busTmrErrorC[11]),
      .busWeOutA(busWeA[11+1]), .busWeOutB(busWeB[11+1]), .busWeOutC(busWeC[11+1]),
      .colAddrOutA(colAddrA[(11+2)*4-1 : (11+1)*4]), .colAddrOutB(colAddrB[(11+2)*4-1 : (11+1)*4]), .colAddrOutC(colAddrC[(11+2)*4-1 : (11+1)*4]),
      .dnData(dataChain[(11+1)*46-1 : 11*46]), .dnHits(hitChain[(11+1)*5-1:11*5]),
      .pixelAddrNextOutA(pixelAddrA[(11+2)*4-1:(11+1)*4]), .pixelAddrNextOutB(pixelAddrB[(11+2)*4-1:(11+1)*4]), .pixelAddrNextOutC(pixelAddrC[(11+2)*4-1:(11+1)*4]),
      .upBCST(BCSTChain[(11+2)*27-1:(11+1)*27]), .upRead(readChain[11+1]), .PAIn(PAIn[11]),
      .VDD_D(VDD_D), .VDD_Dis(VDD_Dis), .VDD_PA(VDD_PA), .VDD_QInj(VDD_QInj),
      .VSS_D(VSS_D), .VSS_Dis(VSS_Dis), .VSS_PA(VSS_PA), .VSS_QInj(VSS_QInj), .VSS_S(VSS_S),
      .CLKRO(ClkRO[11]), .ClkTDC(ClkTDC[11]), .QInj(QInj[11]), .RefStrobe(RefStrobe[11]), .VRef(VRef),
      .busAddrInA(busAddrA[(11+1)*16-1:11*16]), .busAddrInB(busAddrB[(11+1)*16-1:11*16]), .busAddrInC(busAddrC[(11+1)*16-1:11*16]),
      .busClkInA(colClkOutA[11]), .busClkInB(colClkOutB[11]), .busClkInC(colClkOutC[11]),
      .busDataMisoInA(busDataMisoA[(11+2)*8-1 : (11+1)*8]), .busDataMisoInB(busDataMisoB[(11+2)*8-1 : (11+1)*8]), .busDataMisoInC(busDataMisoC[(11+2)*8-1 : (11+1)*8]),
      .busDataMosiInA(busDataMosiA[(11+1)*8-1 : 11*8]), .busDataMosiInB(busDataMosiB[(11+1)*8-1 : 11*8]), .busDataMosiInC(busDataMosiC[(11+1)*8-1 : 11*8]),
      .busReInA(busReA[11]), .busReInB(busReB[11]), .busReInC(busReC[11]),
      .busRstInA(busRstA[11]), .busRstInB(busRstB[11]), .busRstInC(busRstC[11]),
      .busTmrErrorInA(busTmrErrorA[11+1]), .busTmrErrorInB(busTmrErrorB[11+1]), .busTmrErrorInC(busTmrErrorC[11+1]),
      .busWeInA(busWeA[11]), .busWeInB(busWeB[11]), .busWeInC(busWeC[11]),
      .colAddrInA(colAddrA[(11+1)*4-1 : 11*4]), .colAddrInB(colAddrB[(11+1)*4-1 : 11*4]), .colAddrInC(colAddrC[(11+1)*4-1 : 11*4]),
      .dnBCST(BCSTChain[(11+1)*27-1:11*27]), .dnRead(readChain[11]),
      .pixelAddrInA(pixelAddrA[(11+1)*4-1 : 11*4]), .pixelAddrInB(pixelAddrB[(11+1)*4-1 : 11*4]), .pixelAddrInC(pixelAddrC[(11+1)*4-1 : 11*4]),
      .upData(dataChain[(11+2)*46-1 : (11+1)*46]), .upHits(hitChain[(11+2)*5-1 : (11+1)*5]) );

Pixel1 Pixel1_inst_12(
      .PAOut(PAOut[12]),
      .busAddrOutA(busAddrA[(12+2)*16-1 : (12+1)*16]), .busAddrOutB(busAddrB[(12+2)*16-1 : (12+1)*16]), .busAddrOutC(busAddrC[(12+2)*16-1 : (12+1)*16]),
      .busClkOutA(colClkOutA[12+1]), .busClkOutB(colClkOutB[12+1]), .busClkOutC(colClkOutC[12+1]),
      .busDataMisoOutA(busDataMisoA[(12+1)*8-1 : 12*8]), .busDataMisoOutB(busDataMisoB[(12+1)*8-1 : 12*8]), .busDataMisoOutC(busDataMisoC[(12+1)*8-1 : 12*8]),
      .busDataMosiOutA(busDataMosiA[(12+2)*8-1 : (12+1)*8]), .busDataMosiOutB(busDataMosiB[(12+2)*8-1 : (12+1)*8]),
      .busDataMosiOutC(busDataMosiC[(12+2)*8-1 : (12+1)*8]),
      .busReOutA(busReA[12+1]), .busReOutB((busReB[12+1])), .busReOutC(busReC[12+1]),
      .busRstOutA(busRstA[12+1]), .busRstOutB(busRstB[12+1]), .busRstOutC(busRstC[12+1]),
      .busTmrErrorOutA(busTmrErrorA[12]), .busTmrErrorOutB(busTmrErrorB[12]), .busTmrErrorOutC(busTmrErrorC[12]),
      .busWeOutA(busWeA[12+1]), .busWeOutB(busWeB[12+1]), .busWeOutC(busWeC[12+1]),
      .colAddrOutA(colAddrA[(12+2)*4-1 : (12+1)*4]), .colAddrOutB(colAddrB[(12+2)*4-1 : (12+1)*4]), .colAddrOutC(colAddrC[(12+2)*4-1 : (12+1)*4]),
      .dnData(dataChain[(12+1)*46-1 : 12*46]), .dnHits(hitChain[(12+1)*5-1:12*5]),
      .pixelAddrNextOutA(pixelAddrA[(12+2)*4-1:(12+1)*4]), .pixelAddrNextOutB(pixelAddrB[(12+2)*4-1:(12+1)*4]), .pixelAddrNextOutC(pixelAddrC[(12+2)*4-1:(12+1)*4]),
      .upBCST(BCSTChain[(12+2)*27-1:(12+1)*27]), .upRead(readChain[12+1]), .PAIn(PAIn[12]),
      .VDD_D(VDD_D), .VDD_Dis(VDD_Dis), .VDD_PA(VDD_PA), .VDD_QInj(VDD_QInj),
      .VSS_D(VSS_D), .VSS_Dis(VSS_Dis), .VSS_PA(VSS_PA), .VSS_QInj(VSS_QInj), .VSS_S(VSS_S),
      .CLKRO(ClkRO[12]), .ClkTDC(ClkTDC[12]), .QInj(QInj[12]), .RefStrobe(RefStrobe[12]), .VRef(VRef),
      .busAddrInA(busAddrA[(12+1)*16-1:12*16]), .busAddrInB(busAddrB[(12+1)*16-1:12*16]), .busAddrInC(busAddrC[(12+1)*16-1:12*16]),
      .busClkInA(colClkOutA[12]), .busClkInB(colClkOutB[12]), .busClkInC(colClkOutC[12]),
      .busDataMisoInA(busDataMisoA[(12+2)*8-1 : (12+1)*8]), .busDataMisoInB(busDataMisoB[(12+2)*8-1 : (12+1)*8]), .busDataMisoInC(busDataMisoC[(12+2)*8-1 : (12+1)*8]),
      .busDataMosiInA(busDataMosiA[(12+1)*8-1 : 12*8]), .busDataMosiInB(busDataMosiB[(12+1)*8-1 : 12*8]), .busDataMosiInC(busDataMosiC[(12+1)*8-1 : 12*8]),
      .busReInA(busReA[12]), .busReInB(busReB[12]), .busReInC(busReC[12]),
      .busRstInA(busRstA[12]), .busRstInB(busRstB[12]), .busRstInC(busRstC[12]),
      .busTmrErrorInA(busTmrErrorA[12+1]), .busTmrErrorInB(busTmrErrorB[12+1]), .busTmrErrorInC(busTmrErrorC[12+1]),
      .busWeInA(busWeA[12]), .busWeInB(busWeB[12]), .busWeInC(busWeC[12]),
      .colAddrInA(colAddrA[(12+1)*4-1 : 12*4]), .colAddrInB(colAddrB[(12+1)*4-1 : 12*4]), .colAddrInC(colAddrC[(12+1)*4-1 : 12*4]),
      .dnBCST(BCSTChain[(12+1)*27-1:12*27]), .dnRead(readChain[12]),
      .pixelAddrInA(pixelAddrA[(12+1)*4-1 : 12*4]), .pixelAddrInB(pixelAddrB[(12+1)*4-1 : 12*4]), .pixelAddrInC(pixelAddrC[(12+1)*4-1 : 12*4]),
      .upData(dataChain[(12+2)*46-1 : (12+1)*46]), .upHits(hitChain[(12+2)*5-1 : (12+1)*5]) );

Pixel1 Pixel1_inst_13(
      .PAOut(PAOut[13]),
      .busAddrOutA(busAddrA[(13+2)*16-1 : (13+1)*16]), .busAddrOutB(busAddrB[(13+2)*16-1 : (13+1)*16]), .busAddrOutC(busAddrC[(13+2)*16-1 : (13+1)*16]),
      .busClkOutA(colClkOutA[13+1]), .busClkOutB(colClkOutB[13+1]), .busClkOutC(colClkOutC[13+1]),
      .busDataMisoOutA(busDataMisoA[(13+1)*8-1 : 13*8]), .busDataMisoOutB(busDataMisoB[(13+1)*8-1 : 13*8]), .busDataMisoOutC(busDataMisoC[(13+1)*8-1 : 13*8]),
      .busDataMosiOutA(busDataMosiA[(13+2)*8-1 : (13+1)*8]), .busDataMosiOutB(busDataMosiB[(13+2)*8-1 : (13+1)*8]),
      .busDataMosiOutC(busDataMosiC[(13+2)*8-1 : (13+1)*8]),
      .busReOutA(busReA[13+1]), .busReOutB((busReB[13+1])), .busReOutC(busReC[13+1]),
      .busRstOutA(busRstA[13+1]), .busRstOutB(busRstB[13+1]), .busRstOutC(busRstC[13+1]),
      .busTmrErrorOutA(busTmrErrorA[13]), .busTmrErrorOutB(busTmrErrorB[13]), .busTmrErrorOutC(busTmrErrorC[13]),
      .busWeOutA(busWeA[13+1]), .busWeOutB(busWeB[13+1]), .busWeOutC(busWeC[13+1]),
      .colAddrOutA(colAddrA[(13+2)*4-1 : (13+1)*4]), .colAddrOutB(colAddrB[(13+2)*4-1 : (13+1)*4]), .colAddrOutC(colAddrC[(13+2)*4-1 : (13+1)*4]),
      .dnData(dataChain[(13+1)*46-1 : 13*46]), .dnHits(hitChain[(13+1)*5-1:13*5]),
      .pixelAddrNextOutA(pixelAddrA[(13+2)*4-1:(13+1)*4]), .pixelAddrNextOutB(pixelAddrB[(13+2)*4-1:(13+1)*4]), .pixelAddrNextOutC(pixelAddrC[(13+2)*4-1:(13+1)*4]),
      .upBCST(BCSTChain[(13+2)*27-1:(13+1)*27]), .upRead(readChain[13+1]), .PAIn(PAIn[13]),
      .VDD_D(VDD_D), .VDD_Dis(VDD_Dis), .VDD_PA(VDD_PA), .VDD_QInj(VDD_QInj),
      .VSS_D(VSS_D), .VSS_Dis(VSS_Dis), .VSS_PA(VSS_PA), .VSS_QInj(VSS_QInj), .VSS_S(VSS_S),
      .CLKRO(ClkRO[13]), .ClkTDC(ClkTDC[13]), .QInj(QInj[13]), .RefStrobe(RefStrobe[13]), .VRef(VRef),
      .busAddrInA(busAddrA[(13+1)*16-1:13*16]), .busAddrInB(busAddrB[(13+1)*16-1:13*16]), .busAddrInC(busAddrC[(13+1)*16-1:13*16]),
      .busClkInA(colClkOutA[13]), .busClkInB(colClkOutB[13]), .busClkInC(colClkOutC[13]),
      .busDataMisoInA(busDataMisoA[(13+2)*8-1 : (13+1)*8]), .busDataMisoInB(busDataMisoB[(13+2)*8-1 : (13+1)*8]), .busDataMisoInC(busDataMisoC[(13+2)*8-1 : (13+1)*8]),
      .busDataMosiInA(busDataMosiA[(13+1)*8-1 : 13*8]), .busDataMosiInB(busDataMosiB[(13+1)*8-1 : 13*8]), .busDataMosiInC(busDataMosiC[(13+1)*8-1 : 13*8]),
      .busReInA(busReA[13]), .busReInB(busReB[13]), .busReInC(busReC[13]),
      .busRstInA(busRstA[13]), .busRstInB(busRstB[13]), .busRstInC(busRstC[13]),
      .busTmrErrorInA(busTmrErrorA[13+1]), .busTmrErrorInB(busTmrErrorB[13+1]), .busTmrErrorInC(busTmrErrorC[13+1]),
      .busWeInA(busWeA[13]), .busWeInB(busWeB[13]), .busWeInC(busWeC[13]),
      .colAddrInA(colAddrA[(13+1)*4-1 : 13*4]), .colAddrInB(colAddrB[(13+1)*4-1 : 13*4]), .colAddrInC(colAddrC[(13+1)*4-1 : 13*4]),
      .dnBCST(BCSTChain[(13+1)*27-1:13*27]), .dnRead(readChain[13]),
      .pixelAddrInA(pixelAddrA[(13+1)*4-1 : 13*4]), .pixelAddrInB(pixelAddrB[(13+1)*4-1 : 13*4]), .pixelAddrInC(pixelAddrC[(13+1)*4-1 : 13*4]),
      .upData(dataChain[(13+2)*46-1 : (13+1)*46]), .upHits(hitChain[(13+2)*5-1 : (13+1)*5]) );

Pixel1 Pixel1_inst_14(
      .PAOut(PAOut[14]),
      .busAddrOutA(busAddrA[(14+2)*16-1 : (14+1)*16]), .busAddrOutB(busAddrB[(14+2)*16-1 : (14+1)*16]), .busAddrOutC(busAddrC[(14+2)*16-1 : (14+1)*16]),
      .busClkOutA(colClkOutA[14+1]), .busClkOutB(colClkOutB[14+1]), .busClkOutC(colClkOutC[14+1]),
      .busDataMisoOutA(busDataMisoA[(14+1)*8-1 : 14*8]), .busDataMisoOutB(busDataMisoB[(14+1)*8-1 : 14*8]), .busDataMisoOutC(busDataMisoC[(14+1)*8-1 : 14*8]),
      .busDataMosiOutA(busDataMosiA[(14+2)*8-1 : (14+1)*8]), .busDataMosiOutB(busDataMosiB[(14+2)*8-1 : (14+1)*8]),
      .busDataMosiOutC(busDataMosiC[(14+2)*8-1 : (14+1)*8]),
      .busReOutA(busReA[14+1]), .busReOutB((busReB[14+1])), .busReOutC(busReC[14+1]),
      .busRstOutA(busRstA[14+1]), .busRstOutB(busRstB[14+1]), .busRstOutC(busRstC[14+1]),
      .busTmrErrorOutA(busTmrErrorA[14]), .busTmrErrorOutB(busTmrErrorB[14]), .busTmrErrorOutC(busTmrErrorC[14]),
      .busWeOutA(busWeA[14+1]), .busWeOutB(busWeB[14+1]), .busWeOutC(busWeC[14+1]),
      .colAddrOutA(colAddrA[(14+2)*4-1 : (14+1)*4]), .colAddrOutB(colAddrB[(14+2)*4-1 : (14+1)*4]), .colAddrOutC(colAddrC[(14+2)*4-1 : (14+1)*4]),
      .dnData(dataChain[(14+1)*46-1 : 14*46]), .dnHits(hitChain[(14+1)*5-1:14*5]),
      .pixelAddrNextOutA(pixelAddrA[(14+2)*4-1:(14+1)*4]), .pixelAddrNextOutB(pixelAddrB[(14+2)*4-1:(14+1)*4]), .pixelAddrNextOutC(pixelAddrC[(14+2)*4-1:(14+1)*4]),
      .upBCST(BCSTChain[(14+2)*27-1:(14+1)*27]), .upRead(readChain[14+1]), .PAIn(PAIn[14]),
      .VDD_D(VDD_D), .VDD_Dis(VDD_Dis), .VDD_PA(VDD_PA), .VDD_QInj(VDD_QInj),
      .VSS_D(VSS_D), .VSS_Dis(VSS_Dis), .VSS_PA(VSS_PA), .VSS_QInj(VSS_QInj), .VSS_S(VSS_S),
      .CLKRO(ClkRO[14]), .ClkTDC(ClkTDC[14]), .QInj(QInj[14]), .RefStrobe(RefStrobe[14]), .VRef(VRef),
      .busAddrInA(busAddrA[(14+1)*16-1:14*16]), .busAddrInB(busAddrB[(14+1)*16-1:14*16]), .busAddrInC(busAddrC[(14+1)*16-1:14*16]),
      .busClkInA(colClkOutA[14]), .busClkInB(colClkOutB[14]), .busClkInC(colClkOutC[14]),
      .busDataMisoInA(busDataMisoA[(14+2)*8-1 : (14+1)*8]), .busDataMisoInB(busDataMisoB[(14+2)*8-1 : (14+1)*8]), .busDataMisoInC(busDataMisoC[(14+2)*8-1 : (14+1)*8]),
      .busDataMosiInA(busDataMosiA[(14+1)*8-1 : 14*8]), .busDataMosiInB(busDataMosiB[(14+1)*8-1 : 14*8]), .busDataMosiInC(busDataMosiC[(14+1)*8-1 : 14*8]),
      .busReInA(busReA[14]), .busReInB(busReB[14]), .busReInC(busReC[14]),
      .busRstInA(busRstA[14]), .busRstInB(busRstB[14]), .busRstInC(busRstC[14]),
      .busTmrErrorInA(busTmrErrorA[14+1]), .busTmrErrorInB(busTmrErrorB[14+1]), .busTmrErrorInC(busTmrErrorC[14+1]),
      .busWeInA(busWeA[14]), .busWeInB(busWeB[14]), .busWeInC(busWeC[14]),
      .colAddrInA(colAddrA[(14+1)*4-1 : 14*4]), .colAddrInB(colAddrB[(14+1)*4-1 : 14*4]), .colAddrInC(colAddrC[(14+1)*4-1 : 14*4]),
      .dnBCST(BCSTChain[(14+1)*27-1:14*27]), .dnRead(readChain[14]),
      .pixelAddrInA(pixelAddrA[(14+1)*4-1 : 14*4]), .pixelAddrInB(pixelAddrB[(14+1)*4-1 : 14*4]), .pixelAddrInC(pixelAddrC[(14+1)*4-1 : 14*4]),
      .upData(dataChain[(14+2)*46-1 : (14+1)*46]), .upHits(hitChain[(14+2)*5-1 : (14+1)*5]) );

Pixel1 Pixel1_inst_15(
      .PAOut(PAOut[15]),
      .busAddrOutA(busAddrA[(15+2)*16-1 : (15+1)*16]), .busAddrOutB(busAddrB[(15+2)*16-1 : (15+1)*16]), .busAddrOutC(busAddrC[(15+2)*16-1 : (15+1)*16]),
      .busClkOutA(colClkOutA[15+1]), .busClkOutB(colClkOutB[15+1]), .busClkOutC(colClkOutC[15+1]),
      .busDataMisoOutA(busDataMisoA[(15+1)*8-1 : 15*8]), .busDataMisoOutB(busDataMisoB[(15+1)*8-1 : 15*8]), .busDataMisoOutC(busDataMisoC[(15+1)*8-1 : 15*8]),
      .busDataMosiOutA(busDataMosiA[(15+2)*8-1 : (15+1)*8]), .busDataMosiOutB(busDataMosiB[(15+2)*8-1 : (15+1)*8]),
      .busDataMosiOutC(busDataMosiC[(15+2)*8-1 : (15+1)*8]),
      .busReOutA(busReA[15+1]), .busReOutB((busReB[15+1])), .busReOutC(busReC[15+1]),
      .busRstOutA(busRstA[15+1]), .busRstOutB(busRstB[15+1]), .busRstOutC(busRstC[15+1]),
      .busTmrErrorOutA(busTmrErrorA[15]), .busTmrErrorOutB(busTmrErrorB[15]), .busTmrErrorOutC(busTmrErrorC[15]),
      .busWeOutA(busWeA[15+1]), .busWeOutB(busWeB[15+1]), .busWeOutC(busWeC[15+1]),
      .colAddrOutA(colAddrA[(15+2)*4-1 : (15+1)*4]), .colAddrOutB(colAddrB[(15+2)*4-1 : (15+1)*4]), .colAddrOutC(colAddrC[(15+2)*4-1 : (15+1)*4]),
      .dnData(dataChain[(15+1)*46-1 : 15*46]), .dnHits(hitChain[(15+1)*5-1:15*5]),
      .pixelAddrNextOutA(pixelAddrA[(15+2)*4-1:(15+1)*4]), .pixelAddrNextOutB(pixelAddrB[(15+2)*4-1:(15+1)*4]), .pixelAddrNextOutC(pixelAddrC[(15+2)*4-1:(15+1)*4]),
      .upBCST(BCSTChain[(15+2)*27-1:(15+1)*27]), .upRead(readChain[15+1]), .PAIn(PAIn[15]),
      .VDD_D(VDD_D), .VDD_Dis(VDD_Dis), .VDD_PA(VDD_PA), .VDD_QInj(VDD_QInj),
      .VSS_D(VSS_D), .VSS_Dis(VSS_Dis), .VSS_PA(VSS_PA), .VSS_QInj(VSS_QInj), .VSS_S(VSS_S),
      .CLKRO(ClkRO[15]), .ClkTDC(ClkTDC[15]), .QInj(QInj[15]), .RefStrobe(RefStrobe[15]), .VRef(VRef),
      .busAddrInA(busAddrA[(15+1)*16-1:15*16]), .busAddrInB(busAddrB[(15+1)*16-1:15*16]), .busAddrInC(busAddrC[(15+1)*16-1:15*16]),
      .busClkInA(colClkOutA[15]), .busClkInB(colClkOutB[15]), .busClkInC(colClkOutC[15]),
      .busDataMisoInA(busDataMisoA[(15+2)*8-1 : (15+1)*8]), .busDataMisoInB(busDataMisoB[(15+2)*8-1 : (15+1)*8]), .busDataMisoInC(busDataMisoC[(15+2)*8-1 : (15+1)*8]),
      .busDataMosiInA(busDataMosiA[(15+1)*8-1 : 15*8]), .busDataMosiInB(busDataMosiB[(15+1)*8-1 : 15*8]), .busDataMosiInC(busDataMosiC[(15+1)*8-1 : 15*8]),
      .busReInA(busReA[15]), .busReInB(busReB[15]), .busReInC(busReC[15]),
      .busRstInA(busRstA[15]), .busRstInB(busRstB[15]), .busRstInC(busRstC[15]),
      .busTmrErrorInA(busTmrErrorA[15+1]), .busTmrErrorInB(busTmrErrorB[15+1]), .busTmrErrorInC(busTmrErrorC[15+1]),
      .busWeInA(busWeA[15]), .busWeInB(busWeB[15]), .busWeInC(busWeC[15]),
      .colAddrInA(colAddrA[(15+1)*4-1 : 15*4]), .colAddrInB(colAddrB[(15+1)*4-1 : 15*4]), .colAddrInC(colAddrC[(15+1)*4-1 : 15*4]),
      .dnBCST(BCSTChain[(15+1)*27-1:15*27]), .dnRead(readChain[15]),
      .pixelAddrInA(pixelAddrA[(15+1)*4-1 : 15*4]), .pixelAddrInB(pixelAddrB[(15+1)*4-1 : 15*4]), .pixelAddrInC(pixelAddrC[(15+1)*4-1 : 15*4]),
      .upData(dataChain[(15+2)*46-1 : (15+1)*46]), .upHits(hitChain[(15+2)*5-1 : (15+1)*5]) );

busColumnAdapterTMR busColumnAdapterTMR_inst(
      .columnAddrInA(columnAddrInA),
      .columnAddrInB(columnAddrInB),
      .columnAddrInC(columnAddrInC),
      .busRstInA(busRstInA),
      .busRstInB(busRstInB),
      .busRstInC(busRstInC),
      .busWeInA(busWeInA),
      .busWeInB(busWeInB),
      .busWeInC(busWeInC),
      .busClkInA(busClkInA),
      .busClkInB(busClkInB),
      .busClkInC(busClkInC),
      .busReInA(busReInA),
      .busReInB(busReInB),
      .busReInC(busReInC),
      .busAddrInA(busAddrInA),
      .busAddrInB(busAddrInB),
      .busAddrInC(busAddrInC),
      .busDataMosiInA(busDataMosiInA),
      .busDataMosiInB(busDataMosiInB),
      .busDataMosiInC(busDataMosiInC),
      .busDataMisoOutA(busDataMisoOutA),
      .busDataMisoOutB(busDataMisoOutB),
      .busDataMisoOutC(busDataMisoOutC),
      .busTmrErrorOutA(busTmrErrorOutA),
      .busTmrErrorOutB(busTmrErrorOutB),
      .busTmrErrorOutC(busTmrErrorOutC),
      .columnAddrNextOutA(columnAddrNextOutA),
      .columnAddrNextOutB(columnAddrNextOutB),
      .columnAddrNextOutC(columnAddrNextOutC),
      .busRstOutA(busRstOutA),
      .busRstOutB(busRstOutB),
      .busRstOutC(busRstOutC),
      .busWeOutA(busWeOutA),
      .busWeOutB(busWeOutB),
      .busWeOutC(busWeOutC),
      .busClkOutA(busClkOutA),
      .busClkOutB(busClkOutB),
      .busClkOutC(busClkOutC),
      .busReOutA(busReOutA),
      .busReOutB(busReOutB),
      .busReOutC(busReOutC),
      .busAddrOutA(busAddrOutA),
      .busAddrOutB(busAddrOutB),
      .busAddrOutC(busAddrOutC),
      .busDataMosiOutA(busDataMosiOutA),
      .busDataMosiOutB(busDataMosiOutB),
      .busDataMosiOutC(busDataMosiOutC),
      .busDataMisoInA(busDataMisoInA),
      .busDataMisoInB(busDataMisoInB),
      .busDataMisoInC(busDataMisoInC),
      .busTmrErrorInA(busTmrErrorInA),
      .busTmrErrorInB(busTmrErrorInB),
      .busTmrErrorInC(busTmrErrorInC),
      .colRstOutA(busRstA[0]),
      .colRstOutB(busRstB[0]),
      .colRstOutC(busRstC[0]),
      .colWeOutA(busWeA[0]),
      .colWeOutB(busWeB[0]),
      .colWeOutC(busWeC[0]),
      .colClkOutA(colClkOutA[0]),
      .colClkOutB(colClkOutB[0]),
      .colClkOutC(colClkOutC[0]),
      .colReOutA(busReA[0]),
      .colReOutB(busReB[0]),
      .colReOutC(busReC[0]),
      .colAddrOutA(busAddrA[15:0]),
      .colAddrOutB(busAddrB[15:0]),
      .colAddrOutC(busAddrC[15:0]),
      .colDataMosiOutA(busDataMosiA[7:0]),
      .colDataMosiOutB(busDataMosiB[7:0]),
      .colDataMosiOutC(busDataMosiC[7:0]),
      .colDataMisoInA(busDataMisoA[7:0]),
      .colDataMisoInB(busDataMisoB[7:0]),
      .colDataMisoInC(busDataMisoC[7:0]),
      .colTmrErrorInA(busTmrErrorA[0]),
      .colTmrErrorInB(busTmrErrorB[0]),
      .colTmrErrorInC(busTmrErrorC[0]),
      .colIDA(colAddrA[3:0]),
      .colIDB(colAddrB[3:0]),
      .colIDC(colAddrC[3:0]),
      .VDD(VDD_D),
      .VSS(VSS_D)
);

endmodule
