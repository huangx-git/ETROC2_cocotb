//Verilog-AMS HDL for "ETROC_PLL_Sim0", "LJCDR" "verilogams"

`include "constants.vams"
`include "disciplines.vams"

module LJCDR ( DATAOUP, DATAOUTN, clkRefA, clkRefB, clkRefC, instlockPLL, vco5g12n,
vco5g12p, VDD, VSS, BIASDES, BIASGEN_CONFIG, BIASMUX0, BIASMUX1, CLK2G56IN,
CLK2G56IP, CLK2G56QN, CLK2G56QP, CONFIG_FF_CAP, CONFIG_I_CDR, CONFIG_I_FLL,
CONFIG_I_PLL, CONFIG_P_CDR, CONFIG_P_FF_CDR, CONFIG_P_PLL, ENABLE_CDR_R, PLL_R_CONFIG,
VCObiasn, clk40A, clk40B, clk40C, clk40refC, connectCDR, connectPLL, dataMuxCfg1A,
dataMuxCfg1B, dataMuxCfg1C, datan, datap, disDESA, disDESB, disDESC, disDataCounterRef,
enableCDR, enableFD, enablePLL, overrideVcC, refClkSelA, refClkSelB, refClkSelC,
vcoCapSelect, vcoDAC, vcoRailMode, VP, DATASYNC, dataMuxCfg0A, dataMuxCfg0B,
dataMuxCfg0C, overrideVcA, overrideVcB, clk40refA, clk40refB );

  input enableFD;
  input dataMuxCfg1B;
  input dataMuxCfg0A;
  input enablePLL;
  input  [3:0] CONFIG_P_FF_CDR;
  input CLK2G56QN;
  input vcoRailMode;
  input enableCDR;
  input disDESC;
  input  [3:0] CONFIG_P_CDR;
  input disDataCounterRef;
  input dataMuxCfg0B;
  input dataMuxCfg0C;
  input clk40C;
  input BIASMUX1;
  input clk40B;
  input overrideVcB;
  input connectCDR;
  output DATAOUTN;
  input  [3:0] CONFIG_I_CDR;
  inout VDD;
  inout VP;
  input CLK2G56IN;
  output DATAOUP;
  input  [2:0] CONFIG_FF_CAP;
  output instlockPLL;
  input datan;
  input  [3:0] CONFIG_I_FLL;
  input refClkSelC;
  input clk40A;
  output vco5g12n;
  input connectPLL;
  input  [3:0] BIASGEN_CONFIG;
  input VCObiasn;
  input ENABLE_CDR_R;
  input CLK2G56QP;
  input refClkSelA;
  input overrideVcA;
  input overrideVcC;
  input disDESA;
  input clk40refC;
  output DATASYNC;
  output vco5g12p;
  input refClkSelB;
  output clkRefB;
  input BIASDES;
  input dataMuxCfg1C;
  input CLK2G56IP;
  input  [3:0] vcoDAC;
  input clk40refA;
  output clkRefA;
  input BIASMUX0;
  input disDESB;
  input datap;
  input dataMuxCfg1A;
  input  [3:0] CONFIG_P_PLL;
  inout VSS;
  input  [8:0] vcoCapSelect;
  input clk40refB;
  input  [3:0] PLL_R_CONFIG;
  output clkRefC;
  input  [3:0] CONFIG_I_PLL;

localparam real VoHi=1.2, VoLo=0.5;
localparam real tt=10p;

electrical  LPFOut, gnd, vco5g12p, vco5g12n, Vctrl, capSel0, capSel1, capSel2, capSel3, capSel4, capSel5, capSel6, capSel7, capSel8;
ground gnd;

//real Fmax_override, Fmin_override;

wire clk40ref, clk40fb, clkVCO, clk40fb_inv;
assign clk40ref = clk40refA;
assign clk40fb = clk40A;
assign clk40fb_inv = ~clk40fb;

assign clkRefA = clk40refA;
assign clkRefB = clk40refB;
assign clkRefC = clk40refC;

vco_m vco_m_inst(
		.out(clkVCO),
		.in(Vctrl),
		.capSel8(capSel8),
		.capSel7(capSel7),
		.capSel6(capSel6),
		.capSel5(capSel5),
		.capSel4(capSel4),
		.capSel3(capSel3),
		.capSel2(capSel2),
		.capSel1(capSel1),
		.capSel0(capSel0)
);
//DIVIDER DIVIDER_inst(.CLK_VCO(clkVCO),.CLK40(CLK40));
pfd_cp_m pfd_cp_inst(.out(LPFOut), .ref(clk40ref), .vco(clk40fb));
lpf_m LPF_ints(.LPFOut(LPFOut),.gnd(gnd));
PFD_INSTLOCK PFD_INSTLOCK_inst( .CKFB(clk40fb_inv), .CKREF(clk40ref), .UP(UP), .DOWN(DOWN), .INSTLOCK(instlockPLL));

analog begin
	if(overrideVcA == 1'b1 && overrideVcB == 1'b1 && overrideVcC == 1'b1)
		V(Vctrl) <+ 0.6;
	else
		V(Vctrl) <+ V(LPFOut);

	V(capSel0) <+ vcoCapSelect[0];
	V(capSel1) <+ vcoCapSelect[1];
	V(capSel2) <+ vcoCapSelect[2];
	V(capSel3) <+ vcoCapSelect[3];
	V(capSel4) <+ vcoCapSelect[4];
	V(capSel5) <+ vcoCapSelect[5];
	V(capSel6) <+ vcoCapSelect[6];
	V(capSel7) <+ vcoCapSelect[7];
	V(capSel8) <+ vcoCapSelect[8];
	V(vco5g12p) <+ transition(clkVCO? VoHi: VoLo, 0, tt);
	V(vco5g12n) <+ transition(clkVCO? VoLo: VoHi, 0, tt);
end

endmodule
